* power.cir — SPICE subckt for the multi-rail regulator-tree subsystem.
*
* PROJECT-AGNOSTIC: the subckt pins are the subsystem's ABSTRACT interface
* (subsystems/power/power.py INTERFACE), NOT any board net. A consuming project
* wires these pins to its real nets — exactly as the netlist bind map does. The
* active parts (TWO LM61460 SYNCHRONOUS bucks, AP2112K LDO, AO3400A PG-
* sense FET) are mixed-signal switchers/regulators and are NOT modelled as small-
* signal here; this subckt captures the PASSIVE network whose elements span TWO
* interface nets — the per-stage input bypass/bulk + output bulk caps — which is
* what the local test and any board-level .op/.tran reason about. The regulator
* TOPOLOGY (the buck/LDO chain) is documented in the value comments below.
*
* Values mirror subsystems/power/power.py one-for-one (parse_si compatible);
* test_cir_passives_match_netlist enforces equality against the interface-
* spanning netlist caps:
*   C1  100n  +5V buck VIN1/PGND1 HF bypass   (+VIN -> GND)
*   C25 100n  +5V buck VIN2/PGND2 HF bypass   (+VIN -> GND)
*   C2  10u   +5V buck input bulk             (+VIN -> GND)
*   C3  10u   +5V buck input bulk             (+VIN -> GND)
*   C5  22u   +5V buck output bulk            (+VOUT_5V_REG -> GND)
*   C6  22u   +5V buck output bulk            (+VOUT_5V_REG -> GND)
*   C26 22u   +5V buck output bulk            (+VOUT_5V_REG -> GND)
*   C7  100n  +3V3 buck VIN1/PGND1 HF bypass   (+VOUT_5V -> GND)
*   C29 100n  +3V3 buck VIN2/PGND2 HF bypass   (+VOUT_5V -> GND)
*   C8  22u   +3V3 buck input bulk            (+VOUT_5V -> GND)
*   C30 22u   +3V3 buck input bulk            (+VOUT_5V -> GND)
*   C10 22u   +3V3 buck output bulk           (+VOUT_3V3_REG -> GND)
*   C11 22u   +3V3 buck output bulk           (+VOUT_3V3_REG -> GND)
*   C12 1u    +1V8 LDO input cap              (+VOUT_3V3 -> GND)
*   C13 1u    +1V8 LDO output cap             (+VOUT_1V8_REG -> GND)
*
* The remaining passives terminate on a NON-interface (private buck control)
* node and so are NOT subckt elements — documented here for completeness:
*   C4   100n BOOT cap (SW_5V0 <-> BOOT_5V0)        C9  100n BOOT (SW_3V3<->BOOT_3V3)
*   C24  1u   VCC bypass U1 (U1_VCC -> GND)         C31 1u  VCC bypass U2 (U2_VCC -> GND)
*   C28  1u   BIAS bypass U1 (BIAS_5V0 -> GND)      C32 1u  BIAS bypass U2 (BIAS_3V3 -> GND)
*   C27  22p  +5V FB feedforward (-> CFF_5V0)       C23 22p +3V3 FB feedforward (-> CFF_3V3)
*   R1/R2  40.2k/10k  +5V FB divider (-> FB_5V0)    R4/R5  22.1k/10k  +3V3 FB divider
*   R10/R14 22k RT (fSW)  R11/R13 10R BIAS series   R12/R15 1k RFF   R3 1k / R6,R9 330R PG
*   R7 1k / R8 100k  +1V8 PG-sense FET gate stop + pulldown
*
* Port order: VIN VOUT_5V_REG VOUT_5V VOUT_3V3_REG VOUT_3V3 VOUT_1V8_REG VOUT_1V8 GND
* (GND last, by convention; the EN ports carry no subsystem-local two-interface-
*  net passive and so are not subckt pins.)

.subckt power VIN VOUT_5V_REG VOUT_5V VOUT_3V3_REG VOUT_3V3 VOUT_1V8_REG VOUT_1V8 GND

* +5V buck (LM61460) input bypass + bulk (DS SNVSBD5D 9.2.2.5: 2x100n HF + 2x10u)
C1  VIN GND 100n
C25 VIN GND 100n
C2  VIN GND 10u
C3  VIN GND 10u

* +5V buck output bulk (DS 9.2.2.4 Table 9-5: 3x22u on the regulator-side node)
C5  VOUT_5V_REG GND 22u
C6  VOUT_5V_REG GND 22u
C26 VOUT_5V_REG GND 22u

* +3V3 buck (LM61460) input bypass + bulk on the board +5V rail it consumes
* (DS SNVSBD5D 9.2.2.5: 2x100n HF + 2x22u bulk, one HF at each VIN/PGND pair)
C7  VOUT_5V GND 100n
C29 VOUT_5V GND 100n
C8  VOUT_5V GND 22u
C30 VOUT_5V GND 22u

* +3V3 buck output bulk (regulator-side node)
C10 VOUT_3V3_REG GND 22u
C11 VOUT_3V3_REG GND 22u

* +1V8 LDO (AP2112K) input cap on the board +3V3 rail it consumes
C12 VOUT_3V3 GND 1u

* +1V8 LDO output cap (regulator-side node)
C13 VOUT_1V8_REG GND 1u

.ends power

* Standalone smoke harness (ngspice -b runs it; harmless under any project use):
* a 1 V source through 1k onto VIN settles to 1 V at DC across the input bypass.
.subckt _src P
V1 vin 0 1
R1 vin P 1k
.ends _src
.end
