* hdmi_rx.cir — THIN carrier subckt for the HDMI-A sink subsystem.
*
* CARRIER ADAPTER: this is a thin wrapper whose subckt PINS are the carrier's
* REAL external nets (the bound rail/ground/port nets), in contrast to the
* project-agnostic library subckt subsystems/hdmi_rx/hdmi_rx.cir, whose pins are
* the ABSTRACT interface. The real passive network (rail decoupling, the CEC 27k
* pull-up, the 5V-detect divider, ESD shunts) is modelled ONCE in that library
* .cir; see it for the device-level analysis:
*
*     subsystems/hdmi_rx/hdmi_rx.cir
*
* The carrier bind (carrier/subsystems/hdmi_rx/hdmi_rx.py META["bind"]) maps the
* library interface onto these carrier pins:
*     VDD_LOGIC -> +3V3_HDMI_RX   (gated module rail; only the CEC 27k sits here)
*     GND       -> GND
* the four RX TMDS pairs DC-couple connector -> Zynq HR bank 33 (bound to the
* carrier HDMI_RX_* nets), and HDMI_5V_DET / CEC are bound to HDMI_RX_5V_DET /
* HDMI_RX_CEC. SPICE node names cannot begin with '+', so the '+'-prefixed rail
* appears here as the safe token VDD3V3_HDMI_RX (same net, '+' dropped).
*
* This subckt itself carries no passives (they live in the library .cir); each
* pin is tied to ground through a 1G keep-resistor purely so ngspice sees every
* external node and nothing dangles. It is an INTERFACE stub, deliberately R-only
* so a board-level netlist can reference the carrier external nets by name.

.subckt hdmi_rx VDD3V3_HDMI_RX GND CHASSIS_GND
+ HDMI_RX_D2_P HDMI_RX_D2_N
+ HDMI_RX_D1_P HDMI_RX_D1_N
+ HDMI_RX_D0_P HDMI_RX_D0_N
+ HDMI_RX_CLK_P HDMI_RX_CLK_N
+ HDMI_RX_5V_DET HDMI_RX_CEC

* interface keep-resistors (no dangling external node; the real passive network
* is in subsystems/hdmi_rx/hdmi_rx.cir)
Rk1  VDD3V3_HDMI_RX GND 1G
Rk2  CHASSIS_GND GND 1G
Rk3  HDMI_RX_D2_P GND 1G
Rk4  HDMI_RX_D2_N GND 1G
Rk5  HDMI_RX_D1_P GND 1G
Rk6  HDMI_RX_D1_N GND 1G
Rk7  HDMI_RX_D0_P GND 1G
Rk8  HDMI_RX_D0_N GND 1G
Rk9  HDMI_RX_CLK_P GND 1G
Rk10 HDMI_RX_CLK_N GND 1G
Rk11 HDMI_RX_5V_DET GND 1G
Rk12 HDMI_RX_CEC GND 1G

.ends hdmi_rx

* Standalone smoke harness (ngspice -b runs it; harmless under any board use):
* a 1 V source through 1k onto VDD3V3_HDMI_RX settles to ~1 V at DC.
.subckt _src P
V1 vin 0 1
R1 vin P 1k
.ends _src
.end
