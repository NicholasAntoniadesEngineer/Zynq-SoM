* camera.cir — CARRIER-BOUND instance of the camera subsystem (thin subckt).
*
* The PASSIVE small-signal model (the three D-PHY 100R differential
* terminations, the gated-rail bypass, and the two camera-control I2C pull-ups)
* lives ONCE in the project-agnostic library at subsystems/camera/camera.cir,
* whose subckt pins are the ABSTRACT interface (VDD_CAM CSI_* CAM_SCL CAM_SDA
* GND). THIS file is the CARRIER-BOUND view: a thin subckt whose pins are the
* carrier's REAL nets (the bind map in carrier/subsystems/camera/camera.py),
* instantiating that library passive model so a board-level .op/.tran can drop in
* the carrier-bound FFC port by carrier net name.
*
* Carrier bind (abstract -> real, from META["bind"]):
*   VDD_CAM   -> +3V3_CAM   bring-up-gated module rail (SY6280 cell 4)
*   CSI_D0_P/N  -> CAM_D0_P/N    (FFC 3/2 -> bank-35 LVDS_25)
*   CSI_D1_P/N  -> CAM_D1_P/N    (FFC 6/5 -> bank-35 LVDS_25)
*   CSI_CLK_P/N -> CAM_CLK_P/N   (FFC 9/8 -> bank-35 LVDS_25)
*   CAM_SCL   -> CAM_SCL     dedicated camera I2C (CAM_I2C bus)
*   CAM_SDA   -> CAM_SDA
*   GND       -> GND         (identity)
* (CAM_EN / CAM_LED carry no subsystem-local passive, so — as in the library
*  subckt — they are not subckt pins.)
*
* Pin order: V3V3_CAM CAM_D0_P CAM_D0_N CAM_D1_P CAM_D1_N CAM_CLK_P CAM_CLK_N
*            CAM_SCL CAM_SDA GND  (carrier spelling, '+' stripped for SPICE node
* syntax; mirrors the library VDD_CAM CSI_D0_P ... CAM_SCL CAM_SDA GND.)

.subckt camera V3V3_CAM CAM_D0_P CAM_D0_N CAM_D1_P CAM_D1_N CAM_CLK_P CAM_CLK_N CAM_SCL CAM_SDA GND

* Carrier-bound instance of the library passive network. Values mirror
* subsystems/camera/camera.cir one-for-one:
*   R1 100R   D0  diff termination  (CAM_D0_P  -> CAM_D0_N)
*   R2 100R   D1  diff termination  (CAM_D1_P  -> CAM_D1_N)
*   R3 100R   CLK diff termination  (CAM_CLK_P -> CAM_CLK_N)
*   R4 4k7    SCL pull-up           (+3V3_CAM  -> CAM_SCL)
*   R5 4k7    SDA pull-up           (+3V3_CAM  -> CAM_SDA)
*   C1 100n + C2 10u   gated-rail bypass at the FFC  (+3V3_CAM -> GND)
R1 CAM_D0_P  CAM_D0_N  100R
R2 CAM_D1_P  CAM_D1_N  100R
R3 CAM_CLK_P CAM_CLK_N 100R
R4 V3V3_CAM CAM_SCL 4k7
R5 V3V3_CAM CAM_SDA 4k7
C1 V3V3_CAM GND 100n
C2 V3V3_CAM GND 10u

.ends camera

* Standalone smoke harness (ngspice -b runs it; harmless under any board use):
* a 1 V source through 1k onto the carrier camera rail settles to 1 V at DC
* across the bypass.
.subckt _src P
V1 vin 0 1
R1 vin P 1k
.ends _src
.end
