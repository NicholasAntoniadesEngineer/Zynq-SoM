* hdmi_tx.cir — THIN carrier subckt for the TPD12S016 HDMI-source subsystem.
*
* CARRIER ADAPTER: this is a thin wrapper whose subckt PINS are the carrier's
* REAL external nets (the bound rail/ground/port nets), in contrast to the
* project-agnostic library subckt subsystems/hdmi_tx/hdmi_tx.cir, whose pins are
* the ABSTRACT interface (VDD_IO / 5V / GND). The real passive network (rail
* decoupling, the connector +5V bypass, the LS_OE/CT_HPD straps) is modelled
* ONCE in that library .cir; see it for the device-level analysis:
*
*     subsystems/hdmi_tx/hdmi_tx.cir
*
* The carrier bind (carrier/subsystems/hdmi_tx/hdmi_tx.py META["bind"]) maps the
* library interface onto these carrier pins:
*     VDD_IO -> +3V3_HDMI_TX   (V_CCA controller-side gated module rail)
*     5V     -> +5V_HDMI_TX    (V_CC5V load-switch input, gated module rail)
*     GND    -> GND
* and the TMDS/CEC/DDC/HPD ports flow THROUGH the active TPD (no subsystem-local
* passive), bound to the carrier ZYNQ_HDMI_TX_* nets. SPICE node names cannot
* begin with '+', so the '+'-prefixed rails appear here as the safe tokens
* VDD3V3_HDMI_TX / V5V_HDMI_TX (same nets, '+' dropped for the parser).
*
* This subckt itself carries no passives (they live in the library .cir); each
* pin is tied to ground through a 1G keep-resistor purely so ngspice sees every
* external node and nothing dangles. It is an INTERFACE stub, deliberately R-only
* so a board-level netlist can reference the carrier external nets by name.

.subckt hdmi_tx VDD3V3_HDMI_TX V5V_HDMI_TX GND CHASSIS_GND
+ ZYNQ_HDMI_TX_TMDS_2_P ZYNQ_HDMI_TX_TMDS_2_N
+ ZYNQ_HDMI_TX_TMDS_1_P ZYNQ_HDMI_TX_TMDS_1_N
+ ZYNQ_HDMI_TX_TMDS_0_P ZYNQ_HDMI_TX_TMDS_0_N
+ ZYNQ_HDMI_TX_TMDS_CLK_P ZYNQ_HDMI_TX_TMDS_CLK_N
+ ZYNQ_HDMI_TX_CEC ZYNQ_HDMI_TX_SCL ZYNQ_HDMI_TX_SDA ZYNQ_HDMI_TX_HPD

* interface keep-resistors (no dangling external node; the real passive network
* is in subsystems/hdmi_tx/hdmi_tx.cir)
Rk1  VDD3V3_HDMI_TX GND 1G
Rk2  V5V_HDMI_TX GND 1G
Rk3  CHASSIS_GND GND 1G
Rk4  ZYNQ_HDMI_TX_TMDS_2_P GND 1G
Rk5  ZYNQ_HDMI_TX_TMDS_2_N GND 1G
Rk6  ZYNQ_HDMI_TX_TMDS_1_P GND 1G
Rk7  ZYNQ_HDMI_TX_TMDS_1_N GND 1G
Rk8  ZYNQ_HDMI_TX_TMDS_0_P GND 1G
Rk9  ZYNQ_HDMI_TX_TMDS_0_N GND 1G
Rk10 ZYNQ_HDMI_TX_TMDS_CLK_P GND 1G
Rk11 ZYNQ_HDMI_TX_TMDS_CLK_N GND 1G
Rk12 ZYNQ_HDMI_TX_CEC GND 1G
Rk13 ZYNQ_HDMI_TX_SCL GND 1G
Rk14 ZYNQ_HDMI_TX_SDA GND 1G
Rk15 ZYNQ_HDMI_TX_HPD GND 1G

.ends hdmi_tx

* Standalone smoke harness (ngspice -b runs it; harmless under any board use):
* a 1 V source through 1k onto VDD3V3_HDMI_TX settles to ~1 V at DC.
.subckt _src P
V1 vin 0 1
R1 vin P 1k
.ends _src
.end
