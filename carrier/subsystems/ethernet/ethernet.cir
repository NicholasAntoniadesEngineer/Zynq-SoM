* ethernet.cir — THIN carrier subckt for the HX5008NL magnetics subsystem.
*
* CARRIER ADAPTER: this is a thin wrapper whose subckt PINS are the carrier's
* REAL external nets (the bound chassis-ground + the chip/media MDI pairs), in
* contrast to the project-agnostic library subckt subsystems/ethernet/ethernet.cir,
* whose pins are the ABSTRACT interface. The real network (the 1:1 transformer
* windings, the Bob-Smith trunk + 1n/2kV barrier cap, the centre-tap terminations)
* is modelled ONCE in that library .cir; see it for the device-level analysis:
*
*     subsystems/ethernet/ethernet.cir
*
* The carrier bind (carrier/subsystems/ethernet/ethernet.py META["bind"]) maps
* the library interface onto these carrier pins:
*     CHASSIS_GND -> CHASSIS_GND
*     MDIn_P/N    -> ETH_PHY_MDIn_P/N   (CHIP / PHY-side pairs, face the SoM PHY)
*     MXn_P/N     -> ETH_LINE_MDI_n_P/N (MEDIA / RJ45-side pairs, bound by the
*                                        rj45_connector peer)
* There is no power rail on this sheet (the magnetics are passive).
*
* This subckt itself carries no passives (they live in the library .cir); each
* pin is tied to ground through a 1G keep-resistor purely so ngspice sees every
* external node and nothing dangles. It is an INTERFACE stub, deliberately R-only
* so a board-level netlist can reference the carrier external nets by name. (GND
* here is the local SPICE reference for the keep-resistors; the carrier's signal
* GND is internal to the library sheet, kept separate from CHASSIS_GND.)

.subckt ethernet GND CHASSIS_GND
+ ETH_PHY_MDI0_P ETH_PHY_MDI0_N
+ ETH_PHY_MDI1_P ETH_PHY_MDI1_N
+ ETH_PHY_MDI2_P ETH_PHY_MDI2_N
+ ETH_PHY_MDI3_P ETH_PHY_MDI3_N
+ ETH_LINE_MDI_0_P ETH_LINE_MDI_0_N
+ ETH_LINE_MDI_1_P ETH_LINE_MDI_1_N
+ ETH_LINE_MDI_2_P ETH_LINE_MDI_2_N
+ ETH_LINE_MDI_3_P ETH_LINE_MDI_3_N

* interface keep-resistors (no dangling external node; the real passive network
* is in subsystems/ethernet/ethernet.cir)
Rk1  CHASSIS_GND GND 1G
Rk2  ETH_PHY_MDI0_P GND 1G
Rk3  ETH_PHY_MDI0_N GND 1G
Rk4  ETH_PHY_MDI1_P GND 1G
Rk5  ETH_PHY_MDI1_N GND 1G
Rk6  ETH_PHY_MDI2_P GND 1G
Rk7  ETH_PHY_MDI2_N GND 1G
Rk8  ETH_PHY_MDI3_P GND 1G
Rk9  ETH_PHY_MDI3_N GND 1G
Rk10 ETH_LINE_MDI_0_P GND 1G
Rk11 ETH_LINE_MDI_0_N GND 1G
Rk12 ETH_LINE_MDI_1_P GND 1G
Rk13 ETH_LINE_MDI_1_N GND 1G
Rk14 ETH_LINE_MDI_2_P GND 1G
Rk15 ETH_LINE_MDI_2_N GND 1G
Rk16 ETH_LINE_MDI_3_P GND 1G
Rk17 ETH_LINE_MDI_3_N GND 1G

.ends ethernet

* Standalone smoke harness (ngspice -b runs it; harmless under any board use):
* a 1 V source through 1k onto ETH_PHY_MDI0_P settles to ~1 V at DC.
.subckt _src P
V1 vin 0 1
R1 vin P 1k
.ends _src
.end
