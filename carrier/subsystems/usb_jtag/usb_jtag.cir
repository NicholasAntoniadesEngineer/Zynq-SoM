* usb_jtag.cir — CARRIER-BOUND instance of the usb_jtag subsystem (thin subckt).
*
* The PASSIVE small-signal model (the AP2112K LDO decoupling, the CH347/buffer
* VCC bypass, the 8 MHz crystal load caps, and the RST#/MODE-strap/OE pulls)
* lives ONCE in the project-agnostic library at subsystems/usb_jtag/usb_jtag.cir,
* whose subckt pins are the ABSTRACT interface (VBUS_USB 3V3_ISLAND GND). THIS
* file is the CARRIER-BOUND view: a thin subckt whose pins are the carrier's REAL
* nets (the bind map in carrier/subsystems/usb_jtag/usb_jtag.py), instantiating
* that library passive model so a board-level .op/.tran can drop in the
* carrier-bound debug island by carrier net name.
*
* Carrier bind (abstract -> real, from META["bind"]):
*   VBUS_USB    -> +5V_DBG    debug-USB receptacle VBUS (LDO input, cable-only)
*   3V3_ISLAND  -> +3V3_DBG   self-powered island rail (AP2112K output)
*   GND         -> GND        (identity)
* (The USB pair, the four JTAG lines and the two UART lines carry no
*  subsystem-local passive, so — as in the library subckt — they are not subckt
*  pins. The crystal/RST#/MODE/OE nodes stay library-private DBG_* SIGNAL nets.)
*
* Pin order: V5V_DBG V3V3_DBG GND  (carrier spelling, '+' stripped for SPICE
* node syntax; mirrors the library VBUS_USB 3V3_ISLAND GND.)

.subckt usb_jtag V5V_DBG V3V3_DBG GND

* Carrier-bound instance of the library passive network. Values mirror
* subsystems/usb_jtag/usb_jtag.cir one-for-one:
*   C1 1u              LDO Cin            (+5V_DBG  -> GND)
*   C2 10u + C3 100n   LDO Cout / island  (+3V3_DBG -> GND)
*   C4 100n            CH347 VCC bypass   (+3V3_DBG -> GND)
*   C5 100n            SN74LVC125 VCC     (+3V3_DBG -> GND)
*   C6 16p + C7 16p    8 MHz crystal load (DBG_XI/DBG_XO -> GND)
*   R1 10k             CH347 RST# pull-up (+3V3_DBG -> DBG_RST_N)
*   R2 100k            OE# default pull-up(+3V3_DBG -> DBG_JTAG_OE_N)
*   R3 10k             MODE DTR1 pulldown (DBG_MODE_DTR1 -> GND)
*   R4 10k             MODE RTS1 pulldown (DBG_MODE_RTS1 -> GND)
C1 V5V_DBG GND 1u
C2 V3V3_DBG GND 10u
C3 V3V3_DBG GND 100n
C4 V3V3_DBG GND 100n
C5 V3V3_DBG GND 100n
C6 DBG_XI GND 16p
C7 DBG_XO GND 16p
R1 V3V3_DBG DBG_RST_N 10k
R2 V3V3_DBG DBG_JTAG_OE_N 100k
R3 DBG_MODE_DTR1 GND 10k
R4 DBG_MODE_RTS1 GND 10k

.ends usb_jtag

* Standalone smoke harness (ngspice -b runs it; harmless under any board use):
* a 1 V source through 1k onto the carrier island rail settles to 1 V at DC
* across the bypass.
.subckt _src P
V1 vin 0 1
R1 vin P 1k
.ends _src
.end
