* fmc.cir — SPICE subckt for the carrier fmc subsystem (SoM bank-35 IO breakout
* on a generic 2x20 2.54 mm header; was the Samtec FMC LPC connector — see
* fmc.py history).
*
* CARRIER-LOCAL: the subckt pins are the subsystem's real carrier rails. The
* TLV75725 VADJ LDO is an active part with no useful small-signal model here, so
* this subckt captures the PASSIVE network the subsystem adds: the +3V3
* bypass/LDO-input caps and the +2V5_VADJ LDO-output / at-header bypass caps.
* The 14 LA/CLK diff pairs are bare header pins (no subsystem-local passive) and
* so are not subckt pins. (The FMC-mezzanine service straps — PRSNT/PG/JTAG —
* were removed with the connector, so their pull-ups are gone too.)
*
* The VADJ LDO is modelled as an ideal 2.5 V rail for the standalone smoke
* harness; the carrier feeds +2V5_VADJ from U1 in the real netlist.
*
* Values mirror carrier/subsystems/fmc/fmc.py one-for-one (parse_si):
*   C1 10u + C2 100n   +3V3 bypass          (+3V3 -> GND)
*   C3 1u              VADJ LDO input        (+3V3 -> GND)
*   C4 10u + C5 100n   VADJ LDO output / at-header (+2V5_VADJ -> GND)
*
* Port order: the two rails + GND.

.subckt fmc V3V3 VVADJ GND

* +3V3 bypass
C1 V3V3 GND 10u
C2 V3V3 GND 100n

* VADJ LDO input + output / at-header bypass
C3 V3V3  GND 1u
C4 VVADJ GND 10u
C5 VVADJ GND 100n

.ends fmc

* Standalone smoke harness (ngspice -b; harmless under any board use): the
* 2.5 V VADJ rail holds a 10k load through to ground.
.subckt _src P
V1 vvadj 0 2.5
R1 vvadj P 10k
.ends _src
.end
