* som_j3.cir — SPICE subckt for the SoM mezzanine connector J3 subsystem.
*
* CARRIER-LOCAL: the J connectors are the SoM side of the carrier<->SoM
* contract; their nets are real carrier nets (carrier/som_conn_gen.py +
* carrier/som_interface.json), not abstract library names. A board-level .op/
* .tran wires these subckt pins straight onto the same carrier nets.
*
* J3 is a PURE pass-through PLUG (mates the SoM DS receptacle) (Hirose DF40C-100DP-0.4V(51), 100 pins):
* it adds NO on-sheet passive network — no decoupling, no straps, no series/
* termination parts. The PUDC strap and the watchdog parts live on other sheets;
* the placement engine's connector-fan template fires only for a lone >=40-pin
* part. This subckt declares J3's externally-visible POWER/GROUND rails as its
* pins so a board sim can tie the VCCO supplies, and leaves the body empty.
*
* The 74 signal PORT pass-throughs (LCD RGB888 + sync, camera CSI + control,
* FMC clocks/LA pairs, watchdog RST/KICK, PUDC, bank-33/34/35 spares) carry no
* two-rail passive and so are not subckt pins.
*
* Rails (carrier spelling, '+' stripped for SPICE node syntax):
*   V3V3      = +3V3        VCCO source for Zynq bank 34 (LCD LVCMOS33)
*   V2V5_VADJ = +2V5_VADJ   VCCO source for Zynq bank 35 (LVDS_25, camera/FMC)
*
* Port order: V3V3 V2V5_VADJ GND   (GND last, by convention)

.subckt som_j3 V3V3 V2V5_VADJ GND

* Pure pass-through PLUG (mates the SoM DS receptacle): no on-sheet passive network.
* (rails modelled as a tiny resistive tie so the node is not floating in .op)
R3V3 V3V3 GND 1G
R2V5_VADJ V2V5_VADJ GND 1G

.ends som_j3

* Standalone smoke harness (ngspice -b runs it; harmless under any project use):
* a 1 V source through 1k onto V3V3 settles to ~1 V at DC (1G tie is open).
.subckt _src P
V1 vin 0 1
R1 vin P 1k
.ends _src
.end
