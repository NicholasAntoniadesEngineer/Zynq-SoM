* pd_input.cir — THIN carrier subckt for the pd_input ADAPTER (the carrier-bound
* view of the reusable USB-C PD power-inlet subsystem).
*
* The carrier pd_input subsystem is a THIN ADAPTER: it imports the project-
* agnostic library subsystem subsystems/pd_input/ and BINDS its abstract
* interface to the carrier's REAL net names (see carrier/subsystems/pd_input/
* pd_input.py META). The full passive network (inlet bypass + eFuse OVP/ILIM/dVdT
* straps + the dVdT cap + the FLT# pull-up) lives ONCE in the LIBRARY subckt:
*
*     ==> subsystems/pd_input/pd_input.cir   (the authoritative passive model)
*
* This carrier subckt is a thin re-export: it declares the carrier external nets
* as its pins (the bound rails/ports) and instantiates the library subckt, so a
* board-level .op sees the carrier net names while the model stays single-source.
*
* CARRIER BIND (abstract library pin -> carrier external net, per the META):
*   VBUS_CONN  -> +VBUS_IN       (raw receptacle VBUS, ahead of the eFuse)
*   VBUS_OUT   -> +VIN           (fused board bulk; power.py consumes it)
*   VDD_LOGIC  -> +3V3_SC        (always-on SoM logic rail; FLT# pull-up + ESD ref)
*   CC1        -> STM32_USB_CC1  (receptacle CC lines to the FUSB302 / STM32)
*   CC2        -> STM32_USB_CC2
*   USB_D_P    -> STM32_USB_D_P  (FS data pair, post-USBLC6 ESD)
*   USB_D_N    -> STM32_USB_D_N
*   FLT_N      -> PD_FLT_N       (eFuse open-drain fault -> bring-up TCA9535)
*   GND        -> GND
*
* (CHASSIS_GND binds too but, like the library, carries no subsystem-local
*  passive on this sheet and so is not a subckt pin.) Pin order matches the
* library subckt's pin order (GND last, by convention); the eFuse strap internal
* nodes stay PRIVATE to the library subckt, never pins.

.subckt pd_input VBUS_IN VIN 3V3_SC STM32_USB_CC1 STM32_USB_CC2 STM32_USB_D_P STM32_USB_D_N PD_FLT_N GND

* instantiate the library passive model with the carrier nets bound in pin order
* (subsystems/pd_input/pd_input.cir: VBUS_CONN VBUS_OUT VDD_LOGIC CC1 CC2 USB_D_P
*  USB_D_N FLT_N GND)
XPD VBUS_IN VIN 3V3_SC STM32_USB_CC1 STM32_USB_CC2 STM32_USB_D_P STM32_USB_D_N PD_FLT_N GND pd_input

.ends pd_input

* The library subckt definition (the authoritative passive network) lives in
* subsystems/pd_input/pd_input.cir and is .include'd by a board-level deck; this
* thin file is parsed standalone for the local bind-parity test.
.end
