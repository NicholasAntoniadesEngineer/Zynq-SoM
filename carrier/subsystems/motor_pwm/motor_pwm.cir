* motor_pwm.cir — passive network of the 8-ch PWM/ESC output buffer sheet.
* Active parts (HCT245 buffer, SY6280 load switch, 3x8 header) AND the two 4x33R
* output series-damping arrays (RN1/RN2, 4D03WGJ0330T5E) are use_part'd faithful
* parts (not :C/:R), so only the bypass/set DC network is in this .op fixture.
* The 33R elements are passive 33R in series on each PWM signal path
* (U1.B{i} -> RN -> J1.SIG{1+i}); they carry no DC, so they add no .op node.
* Values mirror motor_pwm.py one-for-one (parse_si):
*   C1 100n  HCT245 VCC bypass        (V5 -> GND)
*   C2 100n  SY6280 IN bypass         (V5 -> GND)
*   C3 10u   SY6280 OUT servo hold-up (V5_MOTOR_IO -> GND)
*   R1 10k   #OE pull-up (HiZ fail-safe) (V5 -> ESC_BUF_OE_N)
*   R2 13k   SY6280 ILIM set ~523mA      (MIO_ISET -> GND, internal)
.subckt motor_pwm V5 V5_MOTOR_IO ESC_BUF_OE_N GND
C1 V5 GND 100n
C2 V5 GND 100n
C3 V5_MOTOR_IO GND 10u
R1 V5 ESC_BUF_OE_N 10k
R2 MIO_ISET GND 13k
.ends motor_pwm
.subckt _src P
V1 vin 0 1
R1 vin P 1k
.ends _src
.end
