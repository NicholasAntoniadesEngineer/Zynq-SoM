* lcd.cir — THIN carrier subckt for the lcd ADAPTER (the carrier-bound view of
* the reusable 40-pin TTL RGB LCD + SY7201 backlight subsystem).
*
* The carrier lcd subsystem is a THIN ADAPTER: it imports the project-agnostic
* library subsystem subsystems/lcd/ and BINDS its abstract interface to the
* carrier's REAL net names (see carrier/subsystems/lcd/lcd.py META). The full
* passive network (boost in/out bulk + catch diode + inductor + ISET sense, the
* panel-VDD bypass, the touch-I2C pull-ups + clamp, the DISP / BL_PWM / TP_RST
* default pulls, the PCLK damping) lives ONCE in the LIBRARY subckt:
*
*     ==> subsystems/lcd/lcd.cir   (the authoritative passive model)
*
* This carrier subckt is a thin re-export: it declares the carrier external nets
* as its pins (the bound rails/ports) and instantiates the library subckt, so a
* board-level .op sees the carrier net names while the model stays single-source.
*
* CARRIER BIND (abstract library pin -> carrier external net, per the META):
*   VBOOST_IN    -> +5V_LCD        (gated 5V module rail; boost input)
*   VDD_LCD      -> +3V3_LCD       (gated 3.3V panel-logic + touch rail)
*   VDD_TP_CLAMP -> +3V3           (always-on touch-I2C ESD clamp ref)
*   LCD_DISP     -> LCD_DISP       (display-enable, DISP pull-up leg)
*   TP_SDA       -> LCD_CTP_SDA    (capacitive-touch I2C)
*   TP_SCL       -> LCD_CTP_SCL
*   TP_RST       -> LCD_CTP_RST    (touch reset, pull-down leg)
*   LCD_PCLK     -> LCD_PCLK       (pixel clock, 22R damping)
*   BL_PWM       -> LCD_BL_PWM     (backlight EN/PWM, pull-down leg)
*   GND          -> GND
*
* Pin order matches the library subckt's pin order (GND last, by convention); the
* bare RGB/sync data lines + TP_INT carry no subsystem-local passive and so are
* not subckt pins, exactly as in the library subckt.

.subckt lcd 5V_LCD 3V3_LCD 3V3 LCD_DISP LCD_CTP_SDA LCD_CTP_SCL LCD_CTP_RST LCD_PCLK LCD_BL_PWM GND

* instantiate the library passive model with the carrier nets bound in pin order
* (subsystems/lcd/lcd.cir: VBOOST_IN VDD_LCD VDD_TP_CLAMP LCD_DISP TP_SDA TP_SCL
*  TP_RST LCD_PCLK BL_PWM GND)
XLCD 5V_LCD 3V3_LCD 3V3 LCD_DISP LCD_CTP_SDA LCD_CTP_SCL LCD_CTP_RST LCD_PCLK LCD_BL_PWM GND lcd

.ends lcd

* The library subckt definition (the authoritative passive network) lives in
* subsystems/lcd/lcd.cir and is .include'd by a board-level deck; this thin file
* is parsed standalone for the local bind-parity test (pins == carrier externals).
.end
